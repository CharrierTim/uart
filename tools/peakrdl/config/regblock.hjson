// Copyright Timothee Charrier
// Licensed under the MIT License, see LICENSE for details.
// SPDX-License-Identifier: MIT
//
{
  name:               "regblock",
  human_name:         "SOC Control and Status Registers (CSR)",
  one_line_desc:      "Registers accessible on the AXI4 Lite bus providing control and status functionality.",
  one_paragraph_desc: '''
    Registers accessible on the AXI4 Lite bus providing control and status functionality.
  '''

  cip_id:             "0",
  version:            "1.0.0",
  regwidth:           "32",

  clocking: [
    {
      clock:  "clk_i",
      reset:  "rst_ni"
    }
  ]

  bus_interfaces: [
    {
      protocol:  "tlul",
      direction: "device"
    }
  ]

  registers: [
    {
      name:     "GIT_HASH",
      desc:     "Register indicating the git hash of the repository at the time of bitstream generation.",
      swaccess: "ro",
      hwaccess: "hwo",
      fields: [
        {
          bits: "31:0",
          name: "hash",
          desc: "Hash value"
        }
      ]
    }

    {
      name:     "GIT_STATUS",
      desc:     '''
        Register indicating the git status of the repository at the time of bitstream generation.
        If the value is 1, there were uncommitted changes in the repository (dirty), while if the
        value is 0, there were no uncommitted changes (clean).
      '''
      swaccess: "ro",
      hwaccess: "hwo",
      fields: [
        {
          bits: "0",
          name: "status",
          desc: "Status value"
        }
      ]
    }

    {
      name:     "FPGA_ID",
      desc:     "Register indicating the FPGA identification information.",
      swaccess: "ro",
      hwaccess: "hwo",
      fields: [
        {
          bits: "31:0",
          name: "id",
          desc: "ID value"
        }
      ]
    }

    {
      name:     "SPI_TX_CONTROL",
      desc:     "Register used to send data over SPI. Writing to this register starts the SPI transaction.",
      swaccess: "rw",
      hwaccess: "hro",
      fields: [
        {
          bits: "7:0",
          name: "tx_data",
          desc: "TX data to be sent",
          resval: "0"
        }
        {
          bits: "8",
          name: "tx_data_valid",
          desc: '''
            SPI transaction valid signal. Asserts for one cycle when written 1
            and then clears back to 0 on the next cycle.
          '''
          resval: "0"
        }
      ]
    }

    {
      name:     "SPI_RX_DATA",
      desc:     "Register used to receive data over SPI.",
      swaccess: "ro",
      hwaccess: "hwo",
      fields: [
        {
          bits: "7:0",
          name: "rx_data",
          desc: "RX data received over SPI",
          resval: "0"
        }
      ]
    }

    {
      name:     "VGA_COLOR_CONTROL",
      desc:     '''
        Register used to set the VGA output color.
        The color is specified in RGB format, with 4 bits for each channel (red, green, blue).
      '''
      swaccess: "rw",
      hwaccess: "hro",
      fields: [
        {
          bits: "11:8",
          name: "red",
          desc: "Red channel intensity (0-15)",
          resval: "0"
        }
        {
          bits: "7:4",
          name: "green",
          desc: "Green channel intensity (0-15)",
          resval: "15"
        }
        {
          bits: "3:0",
          name: "blue",
          desc: "Blue channel intensity (0-15)",
          resval: "0"
        }
      ]
    }

    {
      name:     "SWITCH_STATUS",
      desc:     '''
        Register used to read the status of the input switches.
        Each bit corresponds to a different switch, with bit 0 corresponding to switch_0,
        bit 1 to switch_1, and bit 2 to switch_2.
      '''
      swaccess: "ro",
      hwaccess: "hwo",
      fields: [
        {
          bits: "0",
          name: "switch_0",
          desc: "Status of switch 0",
          resval: "0"
        }
        {
          bits: "1",
          name: "switch_1",
          desc: "Status of switch 1",
          resval: "0"
        }
        {
          bits: "2",
          name: "switch_2",
          desc: "Status of switch 2",
          resval: "0"
        }
      ]
    }

    {
      name:     "BAD_ADDRESS_COUNTER",
      desc:     "Register used to count the number of bad address accesses.",
      swaccess: "ro",
      hwaccess: "hrw",
      fields: [
        {
          bits: "31:0",
          name: "count",
          desc: "Counter value, incremented on each bad address access",
          resval: "0"
        }
      ]
    }

    { skipto: "0xF8" }

    {
      name:     "TEST_REGISTER_1",
      desc:     "Register used to test a 32-bit read/write register with all bits used for data.",
      swaccess: "rw",
      hwaccess: "none",
      fields: [
        {
          bits: "31:0",
          name: "test_bits",
          desc: "Test bits",
          resval: "0"
        }
      ]
    }

    {
      name:     "TEST_REGISTER_2",
      desc:     "Register used to test a 32-bit read/write register with all bits used for data.",
      swaccess: "rw",
      hwaccess: "none",
      fields: [
        {
          bits: "31:0",
          name: "test_bits",
          desc: "Test bits",
          resval: "0"
        }
      ]
    }
  ]
}
